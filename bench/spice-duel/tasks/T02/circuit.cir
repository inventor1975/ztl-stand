Inverting opamp (Kuphaldt vol. V ch. 7; op-amp as an E source, open loop 999k; published nominal V(3) = -2.788 at v1 = 1 V)
v1 2 0 dc 1
e 3 0 0 1 999k
r1 3 1 3.29k
r2 1 2 1.18k
.end
