Non-inverting summing amplifier (Purdue Phys536 lecture 14: all resistors 1 %; published by 100 Monte Carlo runs: 0.985 V < vout < 1.008 V)
v3 vin1 0 0.5
v4 vin2 0 0.25
v5 vin3 0 0.25
r1 vin1 sum 1k
r2 vin2 sum 1k
r3 vin3 sum 1k
e1 vout 0 sum fb 1meg
r4 vout fb 400
r5 fb 0 200
.end
