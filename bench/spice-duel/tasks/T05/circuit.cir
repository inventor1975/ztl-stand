Instrumentation amplifier (Kuphaldt vol. V ch. 7; op-amps as E sources; published: v(9) = 3 (v2 - v1)... at v1 = 4 V v(9) = 3.000); here v1 = 4.9 V, v2 = 5 V
v1 1 0 4.9
v2 4 0 dc 5
e1 3 0 1 2 999k
e2 6 0 4 5 999k
e3 9 0 8 7 999k
rload 9 0 10k
r1 2 3 10k
rgain 2 5 10k
r2 5 6 10k
r3 3 7 10k
r4 7 9 10k
r5 6 8 10k
r6 8 0 10k
.end
