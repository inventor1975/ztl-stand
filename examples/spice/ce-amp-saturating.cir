* a common-emitter stage biased by a too-small Rb: it saturates at high BF; BF 100 +-50 %
Vcc vcc 0 12
Rb vcc b 100k
Rc vcc c 1k
Re e 0 100
Q1 c b e qmod
.model qmod NPN(BF=100 Vbe=0.65 Vcesat=0.2 VbeTol=5%)
.end
