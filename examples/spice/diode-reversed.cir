* the same diode reversed: off, no current
V1 a 0 5
R1 a b 1k
D1 0 b dmod
.model dmod D(Vfwd=0.7 Ron=10)
.end
