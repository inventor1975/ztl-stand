* a 5 V divider to 2.5 V
V1 in 0 DC 5
R1 in out 10k
R2 out 0 10k
.op
.end
